** Profile: "SCHEMATIC1-power_protect"  [ C:\Users\bahuy\OneDrive\Desktop\BTL_DIEN\power_verification-pspicefiles\schematic1\power_protect.sim ]

** Creating circuit file "power_protect.cir"
** WARNING: THIS AUTOMATICALLY GENERATED FILE MAY BE OVERWRITTEN BY SUBSEQUENT SIMULATIONS

*Libraries:
* Profile Libraries :
* Local Libraries :
.INC "../../../ltspicemodels-master/ltspicemodels-master/ao3401a.mod"
.INC "../../../smbj-series-thermal-pspice/smbj_thermal_05-07-25_encrypted_w_17-2.lib"
.INC "../../../bzt52b10.lib"
.STMLIB "../../../smbj-series-thermal-pspice/smbj_thermal_05-07-25_encrypted_w_17-2.lib"
.STMLIB "../../../ltspicemodels-master/ltspicemodels-master/ao3401a.asy"
.STMLIB "../../../bzt52b10.lib"
* From [PSPICE NETLIST] section of C:\cds_spb_home\cdssetup\OrCAD_PSpiceTIPSpice_Install\23.1.0\PSpice.ini file:
.lib "nom_pspti.lib"
.lib "nom.lib"

*Analysis directives:
.TRAN  0 5ms 0 1u
.OPTIONS ADVCONV
.OPTIONS FILEMODELSEARCH
.PROBE64 N([N01476])
.PROBE64 N([N01552])
.INC "..\SCHEMATIC1.net"

.END
